.title get_c2q
.include /home/rich/Charlib/CharLib/test/examples/osu350/spice/osu035_stdcells.sp
.include /home/rich/Charlib/CharLib/test/examples/osu350/models/ami035.m
VDD VDD 0 3.3V
VNW VNW 0 3.3V
VPW VPW 0 0.0V
Vo_cap vout wout 0
Cc_load wout 0 0.24pF
Vclk vclk 0 PWL(0s 0.0V 3.1820452787570733e-09s 0.0V 3.2820452787570734e-09s 3.3V 6.464090557514147e-09s 3.3V 6.564090557514147e-09s 0.0V 1.2928181115028293e-08s 0.0V 1.3028181115028293e-08s 3.3V)
Vdata vdata 0 PWL(0s 3.3V 1.2648443528578912e-08s 3.3V 1.2748443528578912e-08s 0.0V 1.2877662291221262e-08s 0.0V 1.2977662291221262e-08s 3.3V)
Xdut vss vdd vdata vdd vdd vout vclk DFFSR
.options TEMP = 25C
.options TNOM = 25C
.options nopage
.options nomod
.options rshunt = 1000000000.0
.options trtol = 1
.tran 0.015ns 1.5959707569978338e-08s 0s
.end
